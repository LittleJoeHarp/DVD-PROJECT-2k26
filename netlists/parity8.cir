Complete 8-bit odd-parity checker: seven XORs, 28 NAND2s, 112 MOSFETs
.include "../models/32nm_MGK.pm"
.options gmin=1e-18 abstol=1e-18 reltol=1e-6 vntol=1e-9
.temp 27
VDD vdd 0 1
V_d0 d0 0 0
V_d1 d1 0 0
V_d2 d2 0 0
V_d3 d3 0 0
V_d4 d4 0 0
V_d5 d5 0 0
V_d6 d6 0 0
V_d7 d7 0 0
M_xor0_0_g1_p1 xor0_0_n1 d0 vdd vdd pmos W=1.2800000000000001e-07 L=3.2000000000000002e-08
M_xor0_0_g1_p2 xor0_0_n1 d1 vdd vdd pmos W=1.2800000000000001e-07 L=3.2000000000000002e-08
M_xor0_0_g1_n1 xor0_0_n1 d0 xor0_0_g1_x 0 nmos W=6.4000000000000004e-08 L=3.2000000000000002e-08
M_xor0_0_g1_n2 xor0_0_g1_x d1 0 0 nmos W=6.4000000000000004e-08 L=3.2000000000000002e-08
M_xor0_0_g2_p1 xor0_0_n2 d0 vdd vdd pmos W=1.2800000000000001e-07 L=3.2000000000000002e-08
M_xor0_0_g2_p2 xor0_0_n2 xor0_0_n1 vdd vdd pmos W=1.2800000000000001e-07 L=3.2000000000000002e-08
M_xor0_0_g2_n1 xor0_0_n2 d0 xor0_0_g2_x 0 nmos W=6.4000000000000004e-08 L=3.2000000000000002e-08
M_xor0_0_g2_n2 xor0_0_g2_x xor0_0_n1 0 0 nmos W=6.4000000000000004e-08 L=3.2000000000000002e-08
M_xor0_0_g3_p1 xor0_0_n3 d1 vdd vdd pmos W=1.2800000000000001e-07 L=3.2000000000000002e-08
M_xor0_0_g3_p2 xor0_0_n3 xor0_0_n1 vdd vdd pmos W=1.2800000000000001e-07 L=3.2000000000000002e-08
M_xor0_0_g3_n1 xor0_0_n3 d1 xor0_0_g3_x 0 nmos W=6.4000000000000004e-08 L=3.2000000000000002e-08
M_xor0_0_g3_n2 xor0_0_g3_x xor0_0_n1 0 0 nmos W=6.4000000000000004e-08 L=3.2000000000000002e-08
M_xor0_0_g4_p1 xor0_0_out xor0_0_n2 vdd vdd pmos W=1.2800000000000001e-07 L=3.2000000000000002e-08
M_xor0_0_g4_p2 xor0_0_out xor0_0_n3 vdd vdd pmos W=1.2800000000000001e-07 L=3.2000000000000002e-08
M_xor0_0_g4_n1 xor0_0_out xor0_0_n2 xor0_0_g4_x 0 nmos W=6.4000000000000004e-08 L=3.2000000000000002e-08
M_xor0_0_g4_n2 xor0_0_g4_x xor0_0_n3 0 0 nmos W=6.4000000000000004e-08 L=3.2000000000000002e-08
M_xor0_1_g1_p1 xor0_1_n1 d2 vdd vdd pmos W=1.2800000000000001e-07 L=3.2000000000000002e-08
M_xor0_1_g1_p2 xor0_1_n1 d3 vdd vdd pmos W=1.2800000000000001e-07 L=3.2000000000000002e-08
M_xor0_1_g1_n1 xor0_1_n1 d2 xor0_1_g1_x 0 nmos W=6.4000000000000004e-08 L=3.2000000000000002e-08
M_xor0_1_g1_n2 xor0_1_g1_x d3 0 0 nmos W=6.4000000000000004e-08 L=3.2000000000000002e-08
M_xor0_1_g2_p1 xor0_1_n2 d2 vdd vdd pmos W=1.2800000000000001e-07 L=3.2000000000000002e-08
M_xor0_1_g2_p2 xor0_1_n2 xor0_1_n1 vdd vdd pmos W=1.2800000000000001e-07 L=3.2000000000000002e-08
M_xor0_1_g2_n1 xor0_1_n2 d2 xor0_1_g2_x 0 nmos W=6.4000000000000004e-08 L=3.2000000000000002e-08
M_xor0_1_g2_n2 xor0_1_g2_x xor0_1_n1 0 0 nmos W=6.4000000000000004e-08 L=3.2000000000000002e-08
M_xor0_1_g3_p1 xor0_1_n3 d3 vdd vdd pmos W=1.2800000000000001e-07 L=3.2000000000000002e-08
M_xor0_1_g3_p2 xor0_1_n3 xor0_1_n1 vdd vdd pmos W=1.2800000000000001e-07 L=3.2000000000000002e-08
M_xor0_1_g3_n1 xor0_1_n3 d3 xor0_1_g3_x 0 nmos W=6.4000000000000004e-08 L=3.2000000000000002e-08
M_xor0_1_g3_n2 xor0_1_g3_x xor0_1_n1 0 0 nmos W=6.4000000000000004e-08 L=3.2000000000000002e-08
M_xor0_1_g4_p1 xor0_1_out xor0_1_n2 vdd vdd pmos W=1.2800000000000001e-07 L=3.2000000000000002e-08
M_xor0_1_g4_p2 xor0_1_out xor0_1_n3 vdd vdd pmos W=1.2800000000000001e-07 L=3.2000000000000002e-08
M_xor0_1_g4_n1 xor0_1_out xor0_1_n2 xor0_1_g4_x 0 nmos W=6.4000000000000004e-08 L=3.2000000000000002e-08
M_xor0_1_g4_n2 xor0_1_g4_x xor0_1_n3 0 0 nmos W=6.4000000000000004e-08 L=3.2000000000000002e-08
M_xor0_2_g1_p1 xor0_2_n1 d4 vdd vdd pmos W=1.2800000000000001e-07 L=3.2000000000000002e-08
M_xor0_2_g1_p2 xor0_2_n1 d5 vdd vdd pmos W=1.2800000000000001e-07 L=3.2000000000000002e-08
M_xor0_2_g1_n1 xor0_2_n1 d4 xor0_2_g1_x 0 nmos W=6.4000000000000004e-08 L=3.2000000000000002e-08
M_xor0_2_g1_n2 xor0_2_g1_x d5 0 0 nmos W=6.4000000000000004e-08 L=3.2000000000000002e-08
M_xor0_2_g2_p1 xor0_2_n2 d4 vdd vdd pmos W=1.2800000000000001e-07 L=3.2000000000000002e-08
M_xor0_2_g2_p2 xor0_2_n2 xor0_2_n1 vdd vdd pmos W=1.2800000000000001e-07 L=3.2000000000000002e-08
M_xor0_2_g2_n1 xor0_2_n2 d4 xor0_2_g2_x 0 nmos W=6.4000000000000004e-08 L=3.2000000000000002e-08
M_xor0_2_g2_n2 xor0_2_g2_x xor0_2_n1 0 0 nmos W=6.4000000000000004e-08 L=3.2000000000000002e-08
M_xor0_2_g3_p1 xor0_2_n3 d5 vdd vdd pmos W=1.2800000000000001e-07 L=3.2000000000000002e-08
M_xor0_2_g3_p2 xor0_2_n3 xor0_2_n1 vdd vdd pmos W=1.2800000000000001e-07 L=3.2000000000000002e-08
M_xor0_2_g3_n1 xor0_2_n3 d5 xor0_2_g3_x 0 nmos W=6.4000000000000004e-08 L=3.2000000000000002e-08
M_xor0_2_g3_n2 xor0_2_g3_x xor0_2_n1 0 0 nmos W=6.4000000000000004e-08 L=3.2000000000000002e-08
M_xor0_2_g4_p1 xor0_2_out xor0_2_n2 vdd vdd pmos W=1.2800000000000001e-07 L=3.2000000000000002e-08
M_xor0_2_g4_p2 xor0_2_out xor0_2_n3 vdd vdd pmos W=1.2800000000000001e-07 L=3.2000000000000002e-08
M_xor0_2_g4_n1 xor0_2_out xor0_2_n2 xor0_2_g4_x 0 nmos W=6.4000000000000004e-08 L=3.2000000000000002e-08
M_xor0_2_g4_n2 xor0_2_g4_x xor0_2_n3 0 0 nmos W=6.4000000000000004e-08 L=3.2000000000000002e-08
M_xor0_3_g1_p1 xor0_3_n1 d6 vdd vdd pmos W=1.2800000000000001e-07 L=3.2000000000000002e-08
M_xor0_3_g1_p2 xor0_3_n1 d7 vdd vdd pmos W=1.2800000000000001e-07 L=3.2000000000000002e-08
M_xor0_3_g1_n1 xor0_3_n1 d6 xor0_3_g1_x 0 nmos W=6.4000000000000004e-08 L=3.2000000000000002e-08
M_xor0_3_g1_n2 xor0_3_g1_x d7 0 0 nmos W=6.4000000000000004e-08 L=3.2000000000000002e-08
M_xor0_3_g2_p1 xor0_3_n2 d6 vdd vdd pmos W=1.2800000000000001e-07 L=3.2000000000000002e-08
M_xor0_3_g2_p2 xor0_3_n2 xor0_3_n1 vdd vdd pmos W=1.2800000000000001e-07 L=3.2000000000000002e-08
M_xor0_3_g2_n1 xor0_3_n2 d6 xor0_3_g2_x 0 nmos W=6.4000000000000004e-08 L=3.2000000000000002e-08
M_xor0_3_g2_n2 xor0_3_g2_x xor0_3_n1 0 0 nmos W=6.4000000000000004e-08 L=3.2000000000000002e-08
M_xor0_3_g3_p1 xor0_3_n3 d7 vdd vdd pmos W=1.2800000000000001e-07 L=3.2000000000000002e-08
M_xor0_3_g3_p2 xor0_3_n3 xor0_3_n1 vdd vdd pmos W=1.2800000000000001e-07 L=3.2000000000000002e-08
M_xor0_3_g3_n1 xor0_3_n3 d7 xor0_3_g3_x 0 nmos W=6.4000000000000004e-08 L=3.2000000000000002e-08
M_xor0_3_g3_n2 xor0_3_g3_x xor0_3_n1 0 0 nmos W=6.4000000000000004e-08 L=3.2000000000000002e-08
M_xor0_3_g4_p1 xor0_3_out xor0_3_n2 vdd vdd pmos W=1.2800000000000001e-07 L=3.2000000000000002e-08
M_xor0_3_g4_p2 xor0_3_out xor0_3_n3 vdd vdd pmos W=1.2800000000000001e-07 L=3.2000000000000002e-08
M_xor0_3_g4_n1 xor0_3_out xor0_3_n2 xor0_3_g4_x 0 nmos W=6.4000000000000004e-08 L=3.2000000000000002e-08
M_xor0_3_g4_n2 xor0_3_g4_x xor0_3_n3 0 0 nmos W=6.4000000000000004e-08 L=3.2000000000000002e-08
M_xor1_0_g1_p1 xor1_0_n1 xor0_0_out vdd vdd pmos W=1.2800000000000001e-07 L=3.2000000000000002e-08
M_xor1_0_g1_p2 xor1_0_n1 xor0_1_out vdd vdd pmos W=1.2800000000000001e-07 L=3.2000000000000002e-08
M_xor1_0_g1_n1 xor1_0_n1 xor0_0_out xor1_0_g1_x 0 nmos W=6.4000000000000004e-08 L=3.2000000000000002e-08
M_xor1_0_g1_n2 xor1_0_g1_x xor0_1_out 0 0 nmos W=6.4000000000000004e-08 L=3.2000000000000002e-08
M_xor1_0_g2_p1 xor1_0_n2 xor0_0_out vdd vdd pmos W=1.2800000000000001e-07 L=3.2000000000000002e-08
M_xor1_0_g2_p2 xor1_0_n2 xor1_0_n1 vdd vdd pmos W=1.2800000000000001e-07 L=3.2000000000000002e-08
M_xor1_0_g2_n1 xor1_0_n2 xor0_0_out xor1_0_g2_x 0 nmos W=6.4000000000000004e-08 L=3.2000000000000002e-08
M_xor1_0_g2_n2 xor1_0_g2_x xor1_0_n1 0 0 nmos W=6.4000000000000004e-08 L=3.2000000000000002e-08
M_xor1_0_g3_p1 xor1_0_n3 xor0_1_out vdd vdd pmos W=1.2800000000000001e-07 L=3.2000000000000002e-08
M_xor1_0_g3_p2 xor1_0_n3 xor1_0_n1 vdd vdd pmos W=1.2800000000000001e-07 L=3.2000000000000002e-08
M_xor1_0_g3_n1 xor1_0_n3 xor0_1_out xor1_0_g3_x 0 nmos W=6.4000000000000004e-08 L=3.2000000000000002e-08
M_xor1_0_g3_n2 xor1_0_g3_x xor1_0_n1 0 0 nmos W=6.4000000000000004e-08 L=3.2000000000000002e-08
M_xor1_0_g4_p1 xor1_0_out xor1_0_n2 vdd vdd pmos W=1.2800000000000001e-07 L=3.2000000000000002e-08
M_xor1_0_g4_p2 xor1_0_out xor1_0_n3 vdd vdd pmos W=1.2800000000000001e-07 L=3.2000000000000002e-08
M_xor1_0_g4_n1 xor1_0_out xor1_0_n2 xor1_0_g4_x 0 nmos W=6.4000000000000004e-08 L=3.2000000000000002e-08
M_xor1_0_g4_n2 xor1_0_g4_x xor1_0_n3 0 0 nmos W=6.4000000000000004e-08 L=3.2000000000000002e-08
M_xor1_1_g1_p1 xor1_1_n1 xor0_2_out vdd vdd pmos W=1.2800000000000001e-07 L=3.2000000000000002e-08
M_xor1_1_g1_p2 xor1_1_n1 xor0_3_out vdd vdd pmos W=1.2800000000000001e-07 L=3.2000000000000002e-08
M_xor1_1_g1_n1 xor1_1_n1 xor0_2_out xor1_1_g1_x 0 nmos W=6.4000000000000004e-08 L=3.2000000000000002e-08
M_xor1_1_g1_n2 xor1_1_g1_x xor0_3_out 0 0 nmos W=6.4000000000000004e-08 L=3.2000000000000002e-08
M_xor1_1_g2_p1 xor1_1_n2 xor0_2_out vdd vdd pmos W=1.2800000000000001e-07 L=3.2000000000000002e-08
M_xor1_1_g2_p2 xor1_1_n2 xor1_1_n1 vdd vdd pmos W=1.2800000000000001e-07 L=3.2000000000000002e-08
M_xor1_1_g2_n1 xor1_1_n2 xor0_2_out xor1_1_g2_x 0 nmos W=6.4000000000000004e-08 L=3.2000000000000002e-08
M_xor1_1_g2_n2 xor1_1_g2_x xor1_1_n1 0 0 nmos W=6.4000000000000004e-08 L=3.2000000000000002e-08
M_xor1_1_g3_p1 xor1_1_n3 xor0_3_out vdd vdd pmos W=1.2800000000000001e-07 L=3.2000000000000002e-08
M_xor1_1_g3_p2 xor1_1_n3 xor1_1_n1 vdd vdd pmos W=1.2800000000000001e-07 L=3.2000000000000002e-08
M_xor1_1_g3_n1 xor1_1_n3 xor0_3_out xor1_1_g3_x 0 nmos W=6.4000000000000004e-08 L=3.2000000000000002e-08
M_xor1_1_g3_n2 xor1_1_g3_x xor1_1_n1 0 0 nmos W=6.4000000000000004e-08 L=3.2000000000000002e-08
M_xor1_1_g4_p1 xor1_1_out xor1_1_n2 vdd vdd pmos W=1.2800000000000001e-07 L=3.2000000000000002e-08
M_xor1_1_g4_p2 xor1_1_out xor1_1_n3 vdd vdd pmos W=1.2800000000000001e-07 L=3.2000000000000002e-08
M_xor1_1_g4_n1 xor1_1_out xor1_1_n2 xor1_1_g4_x 0 nmos W=6.4000000000000004e-08 L=3.2000000000000002e-08
M_xor1_1_g4_n2 xor1_1_g4_x xor1_1_n3 0 0 nmos W=6.4000000000000004e-08 L=3.2000000000000002e-08
M_xor2_0_g1_p1 xor2_0_n1 xor1_0_out vdd vdd pmos W=1.2800000000000001e-07 L=3.2000000000000002e-08
M_xor2_0_g1_p2 xor2_0_n1 xor1_1_out vdd vdd pmos W=1.2800000000000001e-07 L=3.2000000000000002e-08
M_xor2_0_g1_n1 xor2_0_n1 xor1_0_out xor2_0_g1_x 0 nmos W=6.4000000000000004e-08 L=3.2000000000000002e-08
M_xor2_0_g1_n2 xor2_0_g1_x xor1_1_out 0 0 nmos W=6.4000000000000004e-08 L=3.2000000000000002e-08
M_xor2_0_g2_p1 xor2_0_n2 xor1_0_out vdd vdd pmos W=1.2800000000000001e-07 L=3.2000000000000002e-08
M_xor2_0_g2_p2 xor2_0_n2 xor2_0_n1 vdd vdd pmos W=1.2800000000000001e-07 L=3.2000000000000002e-08
M_xor2_0_g2_n1 xor2_0_n2 xor1_0_out xor2_0_g2_x 0 nmos W=6.4000000000000004e-08 L=3.2000000000000002e-08
M_xor2_0_g2_n2 xor2_0_g2_x xor2_0_n1 0 0 nmos W=6.4000000000000004e-08 L=3.2000000000000002e-08
M_xor2_0_g3_p1 xor2_0_n3 xor1_1_out vdd vdd pmos W=1.2800000000000001e-07 L=3.2000000000000002e-08
M_xor2_0_g3_p2 xor2_0_n3 xor2_0_n1 vdd vdd pmos W=1.2800000000000001e-07 L=3.2000000000000002e-08
M_xor2_0_g3_n1 xor2_0_n3 xor1_1_out xor2_0_g3_x 0 nmos W=6.4000000000000004e-08 L=3.2000000000000002e-08
M_xor2_0_g3_n2 xor2_0_g3_x xor2_0_n1 0 0 nmos W=6.4000000000000004e-08 L=3.2000000000000002e-08
M_xor2_0_g4_p1 p xor2_0_n2 vdd vdd pmos W=1.2800000000000001e-07 L=3.2000000000000002e-08
M_xor2_0_g4_p2 p xor2_0_n3 vdd vdd pmos W=1.2800000000000001e-07 L=3.2000000000000002e-08
M_xor2_0_g4_n1 p xor2_0_n2 xor2_0_g4_x 0 nmos W=6.4000000000000004e-08 L=3.2000000000000002e-08
M_xor2_0_g4_n2 xor2_0_g4_x xor2_0_n3 0 0 nmos W=6.4000000000000004e-08 L=3.2000000000000002e-08
.control
set numdgt=17
op
print i(vdd) v(p)
quit 0
.endc
.end
